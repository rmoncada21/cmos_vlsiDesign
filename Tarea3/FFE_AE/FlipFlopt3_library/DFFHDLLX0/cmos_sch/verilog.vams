// Verilog-AMS netlist generated by the AMS netlister, version  IC6.1.7-64b.500.23 .
// Cadence Design Systems, Inc.

`include "disciplines.vams"

(* cds_ams_schematic *)
module DFFHDLLX0 ( QN,CN,D,Q,.gnd(\gnd! ),.vdd(
\vdd! ) );

output   QN;
input   CN;
input   D;
output   Q;
inout  (*
integer
inh_conn_prop_name = "ground_gnd";
integer inh_conn_def_value
 = "cds_globals.\\gnd! ";
 *)
 \gnd! ;
inout  (*
integer
inh_conn_prop_name = "power_vdd";
integer inh_conn_def_value
 = "cds_globals.\\vdd! ";
 *)
 \vdd! ;

ne #(.m(1 * 1), .ad(2.016E-13), .nrd(0.642857), .pd(1.8E-06), .w(420.0n),
 .par1((1 * 1)), .as(2.016E-13), .nrs(0.642857), .ps(1.8E-06), .l(210.0n))
(*
integer library_binding = "PRIMLIB";
integer passed_mfactor = "m";

 *)
M18 ( MQIB, CIB, net64, \gnd!  );
ne #(.m(1 * 1), .ad(2.016E-13), .nrd(0.642857), .pd(1.8E-06), .w(420.0n),
 .par1((1 * 1)), .as(2.016E-13), .nrs(0.642857), .ps(1.8E-06), .l(210.0n))
(*
integer library_binding = "PRIMLIB";
integer passed_mfactor = "m";

 *)
M17 ( MQI, MQIB, \gnd! , \gnd!  );
ne #(.m(1 * 1), .ad(2.016E-13), .nrd(0.642857), .pd(1.8E-06), .w(420.0n),
 .par1((1 * 1)), .as(2.016E-13), .nrs(0.642857), .ps(1.8E-06), .l(210.0n))
(*
integer library_binding = "PRIMLIB";
integer passed_mfactor = "m";

 *)
M15 ( net64, D, \gnd! , \gnd!  );
ne #(.m(1 * 1), .ad(2.016E-13), .nrd(0.642857), .pd(1.8E-06), .w(420.0n),
 .par1((1 * 1)), .as(2.016E-13), .nrs(0.642857), .ps(1.8E-06), .l(210.0n))
(*
integer library_binding = "PRIMLIB";
integer passed_mfactor = "m";

 *)
M46 ( SQIB, CI, net62, \gnd!  );
ne #(.m(1 * 1), .ad(2.016E-13), .nrd(0.642857), .pd(1.8E-06), .w(420.0n),
 .par1((1 * 1)), .as(2.016E-13), .nrs(0.642857), .ps(1.8E-06), .l(210.0n))
(*
integer library_binding = "PRIMLIB";
integer passed_mfactor = "m";

 *)
M19 ( MQIB, CI, net67, \gnd!  );
ne #(.m(1 * 1), .ad(2.016E-13), .nrd(0.642857), .pd(1.8E-06), .w(420.0n),
 .par1((1 * 1)), .as(2.016E-13), .nrs(0.642857), .ps(1.8E-06), .l(210.0n))
(*
integer library_binding = "PRIMLIB";
integer passed_mfactor = "m";

 *)
M51 ( SQIB, CIB, net60, \gnd!  );
ne #(.m(1 * 1), .ad(2.016E-13), .nrd(0.642857), .pd(1.8E-06), .w(420.0n),
 .par1((1 * 1)), .as(2.016E-13), .nrs(0.642857), .ps(1.8E-06), .l(210.0n))
(*
integer library_binding = "PRIMLIB";
integer passed_mfactor = "m";

 *)
M50 ( net60, SQI, \gnd! , \gnd!  );
ne #(.m(1 * 1), .ad(2.304E-13), .nrd(0.5625), .pd(1.92E-06), .w(480.0n),
 .par1((1 * 1)), .as(2.304E-13), .nrs(0.5625), .ps(1.92E-06), .l(210.0n))
(*
integer library_binding = "PRIMLIB";
integer passed_mfactor = "m";

 *)
M49 ( SQI, SQIB, \gnd! , \gnd!  );
ne #(.m(1 * 1), .ad(2.016E-13), .nrd(0.642857), .pd(1.8E-06), .w(420.0n),
 .par1((1 * 1)), .as(2.016E-13), .nrs(0.642857), .ps(1.8E-06), .l(210.0n))
(*
integer library_binding = "PRIMLIB";
integer passed_mfactor = "m";

 *)
M47 ( net62, MQI, \gnd! , \gnd!  );
ne #(.m(1 * 1), .ad(2.016E-13), .nrd(0.642857), .pd(1.8E-06), .w(420.0n),
 .par1((1 * 1)), .as(2.016E-13), .nrs(0.642857), .ps(1.8E-06), .l(210.0n))
(*
integer library_binding = "PRIMLIB";
integer passed_mfactor = "m";

 *)
M61 ( net67, MQI, \gnd! , \gnd!  );

invr #(.lc(2.7e-07), .GT_PDW(420.00n), .sx(4.8e-07), .GT_PDL(210.00n),
 .GT_PUW(720.00n), .GT_PUL(210.00n)) (*
integer library_binding
 = "GATES_HD";
 *)
invr_3 ( .in( SQI ), .out( QN ) );
invr #(.lc(2.7e-07), .GT_PDW(420.0n), .sx(4.8e-07), .GT_PDL(210.00n),
.GT_PUW(720.00n), .GT_PUL(210.00n)) (*
integer library_binding
 = "GATES_HD";
 *)
invr_4 ( .in( SQIB ), .out( Q ) );
invr #(.lc(2.7e-07), .GT_PDW(420.0n), .sx(4.8e-07), .GT_PDL(210.00n),
.GT_PUW(720.00n), .GT_PUL(210.00n)) (*
integer library_binding
 = "GATES_HD";
 *)
invr_2 ( .in( CI ), .out( CIB ) );
invr #(.lc(2.7e-07), .GT_PDW(420.0n), .sx(4.8e-07), .GT_PDL(210.00n),
.GT_PUW(720.00n), .GT_PUL(210.00n)) (*
integer library_binding
 = "GATES_HD";
 *)
invr_1 ( .in( CN ), .out( CI ) );

pe #(.m(1 * 1), .ad(3.384E-13), .nrd(0.382979), .w(705.00n), .pd(2.37E-06),
 .par1((1 * 1)), .as(3.384E-13), .nrs(0.382979), .ps(2.37E-06), .l(210.0n))
(*
integer library_binding = "PRIMLIB";
integer passed_mfactor = "m";

 *)
M24 ( MQIB, CI, net65, \vdd!  );
pe #(.m(1 * 1), .ad(3.456E-13), .nrd(0.375), .pd(2.4E-06), .w(720.0n),
 .par1((1 * 1)), .as(3.456E-13), .nrs(0.375), .ps(2.4E-06), .l(210.0n))
(*
integer library_binding = "PRIMLIB";
integer passed_mfactor = "m";

 *)
M56 ( MQI, MQIB, \vdd! , \vdd!  );
pe #(.m(1 * 1), .ad(3.432E-13), .nrd(0.377622), .pd(2.39E-06), .w(715.00n),
 .par1((1 * 1)), .as(3.432E-13), .nrs(0.377622), .ps(2.39E-06), .l(210.0n))
(*
integer library_binding = "PRIMLIB";
integer passed_mfactor = "m";

 *)
M30 ( net63, MQI, \vdd! , \vdd!  );
pe #(.m(1 * 1), .ad(3.384E-13), .nrd(0.382979), .w(705.00n), .pd(2.37E-06),
 .par1((1 * 1)), .as(3.384E-13), .nrs(0.382979), .ps(2.37E-06), .l(210.0n))
(*
integer library_binding = "PRIMLIB";
integer passed_mfactor = "m";

 *)
M23 ( net65, D, \vdd! , \vdd!  );
pe #(.m(1 * 1), .ad(3.336E-13), .nrd(0.388489), .w(695.00n), .pd(2.35E-06),
 .par1((1 * 1)), .as(3.336E-13), .nrs(0.388489), .ps(2.35E-06), .l(210.0n))
(*
integer library_binding = "PRIMLIB";
integer passed_mfactor = "m";

 *)
M59 ( SQI, SQIB, \vdd! , \vdd!  );
pe #(.m(1 * 1), .ad(2.016E-13), .nrd(0.642857), .pd(1.8E-06), .w(420.0n),
 .par1((1 * 1)), .as(2.016E-13), .nrs(0.642857), .ps(1.8E-06), .l(210.0n))
(*
integer library_binding = "PRIMLIB";
integer passed_mfactor = "m";

 *)
M36 ( net66, SQI, \vdd! , \vdd!  );
pe #(.m(1 * 1), .ad(2.016E-13), .nrd(0.642857), .pd(1.8E-06), .w(420.0n),
 .par1((1 * 1)), .as(2.016E-13), .nrs(0.642857), .ps(1.8E-06), .l(210.0n))
(*
integer library_binding = "PRIMLIB";
integer passed_mfactor = "m";

 *)
M35 ( SQIB, CI, net66, \vdd!  );
pe #(.m(1 * 1), .ad(2.016E-13), .nrd(0.642857), .w(420.0n), .pd(1.8E-06),
 .par1((1 * 1)), .as(2.016E-13), .nrs(0.642857), .ps(1.8E-06), .l(210.0n))
(*
integer library_binding = "PRIMLIB";
integer passed_mfactor = "m";

 *)
M34 ( MQIB, CIB, net58, \vdd!  );
pe #(.m(1 * 1), .ad(3.432E-13), .nrd(0.377622), .pd(2.39E-06), .w(715.00n),
 .par1((1 * 1)), .as(3.432E-13), .nrs(0.377622), .ps(2.39E-06), .l(210.0n))
(*
integer library_binding = "PRIMLIB";
integer passed_mfactor = "m";

 *)
M33 ( SQIB, CIB, net63, \vdd!  );
pe #(.m(1 * 1), .ad(2.016E-13), .nrd(0.642857), .pd(1.8E-06), .w(420.0n),
 .par1((1 * 1)), .as(2.016E-13), .nrs(0.642857), .ps(1.8E-06), .l(210.0n))
(*
integer library_binding = "PRIMLIB";
integer passed_mfactor = "m";

 *)
M28 ( net58, MQI, \vdd! , \vdd!  );

endmodule
